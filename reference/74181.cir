* Auto-Synthesized PTL Circuit with Threshold Fixers
* No .SUBCKT definitions used. Flat topography.

VDD VDD 0 5V
GND GND 0 0V

* --- TRANSISTOR NETLIST ---
M1 BLOCK_OUT_1 B1 GND VDD pmos_mod W=1u L=0.18u
M2 B1_INV_2 B1 VDD VDD pmos_mod W=1u L=0.18u
M3 B1_INV_2 B1 GND GND nmos_mod W=1u L=0.18u
M4 S1 B1_INV_2 BLOCK_OUT_1 VDD pmos_mod W=1u L=0.18u
M5 BLOCK_OUT_3 B1 VDD VDD pmos_mod W=1u L=0.18u
M6 BLOCK_OUT_3 B1 GND GND nmos_mod W=1u L=0.18u
M7 BLOCK_OUT_4 BLOCK_OUT_3 GND VDD pmos_mod W=1u L=0.18u
M8 BLOCK_OUT_3_INV_5 BLOCK_OUT_3 VDD VDD pmos_mod W=1u L=0.18u
M9 BLOCK_OUT_3_INV_5 BLOCK_OUT_3 GND GND nmos_mod W=1u L=0.18u
M10 S0 BLOCK_OUT_3_INV_5 BLOCK_OUT_4 VDD pmos_mod W=1u L=0.18u
M11 BLOCK_OUT_1 A1 BLOCK_OUT_6 VDD pmos_mod W=1u L=0.18u
M12 A1_INV_7 A1 VDD VDD pmos_mod W=1u L=0.18u
M13 A1_INV_7 A1 GND GND nmos_mod W=1u L=0.18u
M14 BLOCK_OUT_6 A1_INV_7 VDD VDD pmos_mod W=1u L=0.18u
M15 BLOCK_OUT_4 BLOCK_OUT_6 BLOCK_OUT_8 VDD pmos_mod W=1u L=0.18u
M16 BLOCK_OUT_6_INV_9 BLOCK_OUT_6 VDD VDD pmos_mod W=1u L=0.18u
M17 BLOCK_OUT_6_INV_9 BLOCK_OUT_6 GND GND nmos_mod W=1u L=0.18u
M18 BLOCK_OUT_8 BLOCK_OUT_6_INV_9 VDD VDD pmos_mod W=1u L=0.18u
M19 BLOCK_OUT_10 BLOCK_OUT_8 VDD VDD pmos_mod W=1u L=0.18u
M20 BLOCK_OUT_10 BLOCK_OUT_8 GND GND nmos_mod W=1u L=0.18u
M21 BUF_MID_11 BLOCK_OUT_10 VDD VDD pmos_mod W=1u L=0.18u
M22 BUF_MID_11 BLOCK_OUT_10 GND GND nmos_mod W=1u L=0.18u
M23 P1 BUF_MID_11 VDD VDD pmos_mod W=1u L=0.18u
M24 P1 BUF_MID_11 GND GND nmos_mod W=1u L=0.18u
M25 BLOCK_OUT_12 Cn VDD VDD pmos_mod W=1u L=0.18u
M26 BLOCK_OUT_12 Cn GND GND nmos_mod W=1u L=0.18u
M27 M BLOCK_OUT_12 BLOCK_OUT_13 VDD pmos_mod W=1u L=0.18u
M28 BLOCK_OUT_12_INV_14 BLOCK_OUT_12 VDD VDD pmos_mod W=1u L=0.18u
M29 BLOCK_OUT_12_INV_14 BLOCK_OUT_12 GND GND nmos_mod W=1u L=0.18u
M30 BLOCK_OUT_13 BLOCK_OUT_12_INV_14 VDD VDD pmos_mod W=1u L=0.18u
M31 BLOCK_OUT_15 BLOCK_OUT_13 VDD VDD pmos_mod W=1u L=0.18u
M32 BLOCK_OUT_15 BLOCK_OUT_13 GND GND nmos_mod W=1u L=0.18u
M33 BUF_MID_16 BLOCK_OUT_15 VDD VDD pmos_mod W=1u L=0.18u
M34 BUF_MID_16 BLOCK_OUT_15 GND GND nmos_mod W=1u L=0.18u
M35 C0 BUF_MID_16 VDD VDD pmos_mod W=1u L=0.18u
M36 C0 BUF_MID_16 GND GND nmos_mod W=1u L=0.18u
M37 BLOCK_OUT_17 A1 GND VDD pmos_mod W=1u L=0.18u
M38 B1 A1_INV_7 BLOCK_OUT_17 VDD pmos_mod W=1u L=0.18u
M39 BLOCK_OUT_18 BLOCK_OUT_17 GND VDD pmos_mod W=1u L=0.18u
M40 BLOCK_OUT_17_INV_19 BLOCK_OUT_17 VDD VDD pmos_mod W=1u L=0.18u
M41 BLOCK_OUT_17_INV_19 BLOCK_OUT_17 GND GND nmos_mod W=1u L=0.18u
M42 S3 BLOCK_OUT_17_INV_19 BLOCK_OUT_18 VDD pmos_mod W=1u L=0.18u
M43 BLOCK_OUT_20 BLOCK_OUT_3 GND VDD pmos_mod W=1u L=0.18u
M44 S2 BLOCK_OUT_3_INV_5 BLOCK_OUT_20 VDD pmos_mod W=1u L=0.18u
M45 BLOCK_OUT_21 A1 GND VDD pmos_mod W=1u L=0.18u
M46 BLOCK_OUT_20 A1_INV_7 BLOCK_OUT_21 VDD pmos_mod W=1u L=0.18u
M47 BLOCK_OUT_21 BLOCK_OUT_18 BLOCK_OUT_22 VDD pmos_mod W=1u L=0.18u
M48 BLOCK_OUT_18_INV_23 BLOCK_OUT_18 VDD VDD pmos_mod W=1u L=0.18u
M49 BLOCK_OUT_18_INV_23 BLOCK_OUT_18 GND GND nmos_mod W=1u L=0.18u
M50 BLOCK_OUT_22 BLOCK_OUT_18_INV_23 VDD VDD pmos_mod W=1u L=0.18u
M51 BLOCK_OUT_24 BLOCK_OUT_22 VDD VDD pmos_mod W=1u L=0.18u
M52 BLOCK_OUT_24 BLOCK_OUT_22 GND GND nmos_mod W=1u L=0.18u
M53 BUF_MID_25 BLOCK_OUT_24 VDD VDD pmos_mod W=1u L=0.18u
M54 BUF_MID_25 BLOCK_OUT_24 GND GND nmos_mod W=1u L=0.18u
M55 G1 BUF_MID_25 VDD VDD pmos_mod W=1u L=0.18u
M56 G1 BUF_MID_25 GND GND nmos_mod W=1u L=0.18u
M57 BLOCK_OUT_26 A3 GND VDD pmos_mod W=1u L=0.18u
M58 A3_INV_27 A3 VDD VDD pmos_mod W=1u L=0.18u
M59 A3_INV_27 A3 GND GND nmos_mod W=1u L=0.18u
M60 B3 A3_INV_27 BLOCK_OUT_26 VDD pmos_mod W=1u L=0.18u
M61 BLOCK_OUT_28 BLOCK_OUT_26 GND VDD pmos_mod W=1u L=0.18u
M62 BLOCK_OUT_26_INV_29 BLOCK_OUT_26 VDD VDD pmos_mod W=1u L=0.18u
M63 BLOCK_OUT_26_INV_29 BLOCK_OUT_26 GND GND nmos_mod W=1u L=0.18u
M64 S3 BLOCK_OUT_26_INV_29 BLOCK_OUT_28 VDD pmos_mod W=1u L=0.18u
M65 BLOCK_OUT_30 B3 VDD VDD pmos_mod W=1u L=0.18u
M66 BLOCK_OUT_30 B3 GND GND nmos_mod W=1u L=0.18u
M67 BLOCK_OUT_31 BLOCK_OUT_30 GND VDD pmos_mod W=1u L=0.18u
M68 BLOCK_OUT_30_INV_32 BLOCK_OUT_30 VDD VDD pmos_mod W=1u L=0.18u
M69 BLOCK_OUT_30_INV_32 BLOCK_OUT_30 GND GND nmos_mod W=1u L=0.18u
M70 S2 BLOCK_OUT_30_INV_32 BLOCK_OUT_31 VDD pmos_mod W=1u L=0.18u
M71 BLOCK_OUT_33 A3 GND VDD pmos_mod W=1u L=0.18u
M72 BLOCK_OUT_31 A3_INV_27 BLOCK_OUT_33 VDD pmos_mod W=1u L=0.18u
M73 BLOCK_OUT_33 BLOCK_OUT_28 BLOCK_OUT_34 VDD pmos_mod W=1u L=0.18u
M74 BLOCK_OUT_28_INV_35 BLOCK_OUT_28 VDD VDD pmos_mod W=1u L=0.18u
M75 BLOCK_OUT_28_INV_35 BLOCK_OUT_28 GND GND nmos_mod W=1u L=0.18u
M76 BLOCK_OUT_34 BLOCK_OUT_28_INV_35 VDD VDD pmos_mod W=1u L=0.18u
M77 BLOCK_OUT_36 BLOCK_OUT_34 VDD VDD pmos_mod W=1u L=0.18u
M78 BLOCK_OUT_36 BLOCK_OUT_34 GND GND nmos_mod W=1u L=0.18u
M79 BUF_MID_37 BLOCK_OUT_36 VDD VDD pmos_mod W=1u L=0.18u
M80 BUF_MID_37 BLOCK_OUT_36 GND GND nmos_mod W=1u L=0.18u
M81 G3 BUF_MID_37 VDD VDD pmos_mod W=1u L=0.18u
M82 G3 BUF_MID_37 GND GND nmos_mod W=1u L=0.18u
M83 BLOCK_OUT_38 B3 GND VDD pmos_mod W=1u L=0.18u
M84 B3_INV_39 B3 VDD VDD pmos_mod W=1u L=0.18u
M85 B3_INV_39 B3 GND GND nmos_mod W=1u L=0.18u
M86 S1 B3_INV_39 BLOCK_OUT_38 VDD pmos_mod W=1u L=0.18u
M87 BLOCK_OUT_40 BLOCK_OUT_30 GND VDD pmos_mod W=1u L=0.18u
M88 S0 BLOCK_OUT_30_INV_32 BLOCK_OUT_40 VDD pmos_mod W=1u L=0.18u
M89 BLOCK_OUT_38 A3 BLOCK_OUT_41 VDD pmos_mod W=1u L=0.18u
M90 BLOCK_OUT_41 A3_INV_27 VDD VDD pmos_mod W=1u L=0.18u
M91 BLOCK_OUT_40 BLOCK_OUT_41 BLOCK_OUT_42 VDD pmos_mod W=1u L=0.18u
M92 BLOCK_OUT_41_INV_43 BLOCK_OUT_41 VDD VDD pmos_mod W=1u L=0.18u
M93 BLOCK_OUT_41_INV_43 BLOCK_OUT_41 GND GND nmos_mod W=1u L=0.18u
M94 BLOCK_OUT_42 BLOCK_OUT_41_INV_43 VDD VDD pmos_mod W=1u L=0.18u
M95 BLOCK_OUT_44 BLOCK_OUT_42 VDD VDD pmos_mod W=1u L=0.18u
M96 BLOCK_OUT_44 BLOCK_OUT_42 GND GND nmos_mod W=1u L=0.18u
M97 BUF_MID_45 BLOCK_OUT_44 VDD VDD pmos_mod W=1u L=0.18u
M98 BUF_MID_45 BLOCK_OUT_44 GND GND nmos_mod W=1u L=0.18u
M99 P3 BUF_MID_45 VDD VDD pmos_mod W=1u L=0.18u
M100 P3 BUF_MID_45 GND GND nmos_mod W=1u L=0.18u
M101 BLOCK_OUT_46 B0 GND VDD pmos_mod W=1u L=0.18u
M102 B0_INV_47 B0 VDD VDD pmos_mod W=1u L=0.18u
M103 B0_INV_47 B0 GND GND nmos_mod W=1u L=0.18u
M104 S1 B0_INV_47 BLOCK_OUT_46 VDD pmos_mod W=1u L=0.18u
M105 BLOCK_OUT_48 B0 VDD VDD pmos_mod W=1u L=0.18u
M106 BLOCK_OUT_48 B0 GND GND nmos_mod W=1u L=0.18u
M107 BLOCK_OUT_49 BLOCK_OUT_48 GND VDD pmos_mod W=1u L=0.18u
M108 BLOCK_OUT_48_INV_50 BLOCK_OUT_48 VDD VDD pmos_mod W=1u L=0.18u
M109 BLOCK_OUT_48_INV_50 BLOCK_OUT_48 GND GND nmos_mod W=1u L=0.18u
M110 S0 BLOCK_OUT_48_INV_50 BLOCK_OUT_49 VDD pmos_mod W=1u L=0.18u
M111 BLOCK_OUT_46 A0 BLOCK_OUT_51 VDD pmos_mod W=1u L=0.18u
M112 A0_INV_52 A0 VDD VDD pmos_mod W=1u L=0.18u
M113 A0_INV_52 A0 GND GND nmos_mod W=1u L=0.18u
M114 BLOCK_OUT_51 A0_INV_52 VDD VDD pmos_mod W=1u L=0.18u
M115 BLOCK_OUT_49 BLOCK_OUT_51 BLOCK_OUT_53 VDD pmos_mod W=1u L=0.18u
M116 BLOCK_OUT_51_INV_54 BLOCK_OUT_51 VDD VDD pmos_mod W=1u L=0.18u
M117 BLOCK_OUT_51_INV_54 BLOCK_OUT_51 GND GND nmos_mod W=1u L=0.18u
M118 BLOCK_OUT_53 BLOCK_OUT_51_INV_54 VDD VDD pmos_mod W=1u L=0.18u
M119 BLOCK_OUT_55 BLOCK_OUT_53 VDD VDD pmos_mod W=1u L=0.18u
M120 BLOCK_OUT_55 BLOCK_OUT_53 GND GND nmos_mod W=1u L=0.18u
M121 BUF_MID_56 BLOCK_OUT_55 VDD VDD pmos_mod W=1u L=0.18u
M122 BUF_MID_56 BLOCK_OUT_55 GND GND nmos_mod W=1u L=0.18u
M123 P0 BUF_MID_56 VDD VDD pmos_mod W=1u L=0.18u
M124 P0 BUF_MID_56 GND GND nmos_mod W=1u L=0.18u
M125 BLOCK_OUT_57 A2 GND VDD pmos_mod W=1u L=0.18u
M126 A2_INV_58 A2 VDD VDD pmos_mod W=1u L=0.18u
M127 A2_INV_58 A2 GND GND nmos_mod W=1u L=0.18u
M128 B2 A2_INV_58 BLOCK_OUT_57 VDD pmos_mod W=1u L=0.18u
M129 BLOCK_OUT_59 BLOCK_OUT_57 GND VDD pmos_mod W=1u L=0.18u
M130 BLOCK_OUT_57_INV_60 BLOCK_OUT_57 VDD VDD pmos_mod W=1u L=0.18u
M131 BLOCK_OUT_57_INV_60 BLOCK_OUT_57 GND GND nmos_mod W=1u L=0.18u
M132 S3 BLOCK_OUT_57_INV_60 BLOCK_OUT_59 VDD pmos_mod W=1u L=0.18u
M133 BLOCK_OUT_61 B2 VDD VDD pmos_mod W=1u L=0.18u
M134 BLOCK_OUT_61 B2 GND GND nmos_mod W=1u L=0.18u
M135 BLOCK_OUT_62 BLOCK_OUT_61 GND VDD pmos_mod W=1u L=0.18u
M136 BLOCK_OUT_61_INV_63 BLOCK_OUT_61 VDD VDD pmos_mod W=1u L=0.18u
M137 BLOCK_OUT_61_INV_63 BLOCK_OUT_61 GND GND nmos_mod W=1u L=0.18u
M138 S2 BLOCK_OUT_61_INV_63 BLOCK_OUT_62 VDD pmos_mod W=1u L=0.18u
M139 BLOCK_OUT_64 A2 GND VDD pmos_mod W=1u L=0.18u
M140 BLOCK_OUT_62 A2_INV_58 BLOCK_OUT_64 VDD pmos_mod W=1u L=0.18u
M141 BLOCK_OUT_64 BLOCK_OUT_59 BLOCK_OUT_65 VDD pmos_mod W=1u L=0.18u
M142 BLOCK_OUT_59_INV_66 BLOCK_OUT_59 VDD VDD pmos_mod W=1u L=0.18u
M143 BLOCK_OUT_59_INV_66 BLOCK_OUT_59 GND GND nmos_mod W=1u L=0.18u
M144 BLOCK_OUT_65 BLOCK_OUT_59_INV_66 VDD VDD pmos_mod W=1u L=0.18u
M145 BLOCK_OUT_67 BLOCK_OUT_65 VDD VDD pmos_mod W=1u L=0.18u
M146 BLOCK_OUT_67 BLOCK_OUT_65 GND GND nmos_mod W=1u L=0.18u
M147 BUF_MID_68 BLOCK_OUT_67 VDD VDD pmos_mod W=1u L=0.18u
M148 BUF_MID_68 BLOCK_OUT_67 GND GND nmos_mod W=1u L=0.18u
M149 G2 BUF_MID_68 VDD VDD pmos_mod W=1u L=0.18u
M150 G2 BUF_MID_68 GND GND nmos_mod W=1u L=0.18u
M151 BLOCK_OUT_69 B2 GND VDD pmos_mod W=1u L=0.18u
M152 B2_INV_70 B2 VDD VDD pmos_mod W=1u L=0.18u
M153 B2_INV_70 B2 GND GND nmos_mod W=1u L=0.18u
M154 S1 B2_INV_70 BLOCK_OUT_69 VDD pmos_mod W=1u L=0.18u
M155 BLOCK_OUT_71 BLOCK_OUT_61 GND VDD pmos_mod W=1u L=0.18u
M156 S0 BLOCK_OUT_61_INV_63 BLOCK_OUT_71 VDD pmos_mod W=1u L=0.18u
M157 BLOCK_OUT_69 A2 BLOCK_OUT_72 VDD pmos_mod W=1u L=0.18u
M158 BLOCK_OUT_72 A2_INV_58 VDD VDD pmos_mod W=1u L=0.18u
M159 BLOCK_OUT_71 BLOCK_OUT_72 BLOCK_OUT_73 VDD pmos_mod W=1u L=0.18u
M160 BLOCK_OUT_72_INV_74 BLOCK_OUT_72 VDD VDD pmos_mod W=1u L=0.18u
M161 BLOCK_OUT_72_INV_74 BLOCK_OUT_72 GND GND nmos_mod W=1u L=0.18u
M162 BLOCK_OUT_73 BLOCK_OUT_72_INV_74 VDD VDD pmos_mod W=1u L=0.18u
M163 BLOCK_OUT_75 BLOCK_OUT_73 VDD VDD pmos_mod W=1u L=0.18u
M164 BLOCK_OUT_75 BLOCK_OUT_73 GND GND nmos_mod W=1u L=0.18u
M165 BUF_MID_76 BLOCK_OUT_75 VDD VDD pmos_mod W=1u L=0.18u
M166 BUF_MID_76 BLOCK_OUT_75 GND GND nmos_mod W=1u L=0.18u
M167 P2 BUF_MID_76 VDD VDD pmos_mod W=1u L=0.18u
M168 P2 BUF_MID_76 GND GND nmos_mod W=1u L=0.18u
M169 BLOCK_OUT_77 A0 GND VDD pmos_mod W=1u L=0.18u
M170 B0 A0_INV_52 BLOCK_OUT_77 VDD pmos_mod W=1u L=0.18u
M171 BLOCK_OUT_78 BLOCK_OUT_77 GND VDD pmos_mod W=1u L=0.18u
M172 BLOCK_OUT_77_INV_79 BLOCK_OUT_77 VDD VDD pmos_mod W=1u L=0.18u
M173 BLOCK_OUT_77_INV_79 BLOCK_OUT_77 GND GND nmos_mod W=1u L=0.18u
M174 S3 BLOCK_OUT_77_INV_79 BLOCK_OUT_78 VDD pmos_mod W=1u L=0.18u
M175 BLOCK_OUT_80 BLOCK_OUT_48 GND VDD pmos_mod W=1u L=0.18u
M176 S2 BLOCK_OUT_48_INV_50 BLOCK_OUT_80 VDD pmos_mod W=1u L=0.18u
M177 BLOCK_OUT_81 A0 GND VDD pmos_mod W=1u L=0.18u
M178 BLOCK_OUT_80 A0_INV_52 BLOCK_OUT_81 VDD pmos_mod W=1u L=0.18u
M179 BLOCK_OUT_81 BLOCK_OUT_78 BLOCK_OUT_82 VDD pmos_mod W=1u L=0.18u
M180 BLOCK_OUT_78_INV_83 BLOCK_OUT_78 VDD VDD pmos_mod W=1u L=0.18u
M181 BLOCK_OUT_78_INV_83 BLOCK_OUT_78 GND GND nmos_mod W=1u L=0.18u
M182 BLOCK_OUT_82 BLOCK_OUT_78_INV_83 VDD VDD pmos_mod W=1u L=0.18u
M183 BLOCK_OUT_84 BLOCK_OUT_82 VDD VDD pmos_mod W=1u L=0.18u
M184 BLOCK_OUT_84 BLOCK_OUT_82 GND GND nmos_mod W=1u L=0.18u
M185 BUF_MID_85 BLOCK_OUT_84 VDD VDD pmos_mod W=1u L=0.18u
M186 BUF_MID_85 BLOCK_OUT_84 GND GND nmos_mod W=1u L=0.18u
M187 G0 BUF_MID_85 VDD VDD pmos_mod W=1u L=0.18u
M188 G0 BUF_MID_85 GND GND nmos_mod W=1u L=0.18u
M189 BLOCK_OUT_86 G0 GND VDD pmos_mod W=1u L=0.18u
M190 G0_INV_87 G0 VDD VDD pmos_mod W=1u L=0.18u
M191 G0_INV_87 G0 GND GND nmos_mod W=1u L=0.18u
M192 P1 G0_INV_87 BLOCK_OUT_86 VDD pmos_mod W=1u L=0.18u
M193 BLOCK_OUT_88 BLOCK_OUT_12 GND VDD pmos_mod W=1u L=0.18u
M194 P0 BLOCK_OUT_12_INV_14 BLOCK_OUT_88 VDD pmos_mod W=1u L=0.18u
M195 BLOCK_OUT_89 BLOCK_OUT_88 GND VDD pmos_mod W=1u L=0.18u
M196 BLOCK_OUT_88_INV_90 BLOCK_OUT_88 VDD VDD pmos_mod W=1u L=0.18u
M197 BLOCK_OUT_88_INV_90 BLOCK_OUT_88 GND GND nmos_mod W=1u L=0.18u
M198 P1 BLOCK_OUT_88_INV_90 BLOCK_OUT_89 VDD pmos_mod W=1u L=0.18u
M199 BLOCK_OUT_89 BLOCK_OUT_86 BLOCK_OUT_91 VDD pmos_mod W=1u L=0.18u
M200 BLOCK_OUT_86_INV_92 BLOCK_OUT_86 VDD VDD pmos_mod W=1u L=0.18u
M201 BLOCK_OUT_86_INV_92 BLOCK_OUT_86 GND GND nmos_mod W=1u L=0.18u
M202 BLOCK_OUT_91 BLOCK_OUT_86_INV_92 VDD VDD pmos_mod W=1u L=0.18u
M203 G1 BLOCK_OUT_91 BLOCK_OUT_93 VDD pmos_mod W=1u L=0.18u
M204 BLOCK_OUT_91_INV_94 BLOCK_OUT_91 VDD VDD pmos_mod W=1u L=0.18u
M205 BLOCK_OUT_91_INV_94 BLOCK_OUT_91 GND GND nmos_mod W=1u L=0.18u
M206 BLOCK_OUT_93 BLOCK_OUT_91_INV_94 VDD VDD pmos_mod W=1u L=0.18u
M207 M BLOCK_OUT_93 BLOCK_OUT_95 VDD pmos_mod W=1u L=0.18u
M208 BLOCK_OUT_93_INV_96 BLOCK_OUT_93 VDD VDD pmos_mod W=1u L=0.18u
M209 BLOCK_OUT_93_INV_96 BLOCK_OUT_93 GND GND nmos_mod W=1u L=0.18u
M210 BLOCK_OUT_95 BLOCK_OUT_93_INV_96 VDD VDD pmos_mod W=1u L=0.18u
M211 BLOCK_OUT_97 BLOCK_OUT_95 VDD VDD pmos_mod W=1u L=0.18u
M212 BLOCK_OUT_97 BLOCK_OUT_95 GND GND nmos_mod W=1u L=0.18u
M213 BUF_MID_98 BLOCK_OUT_97 VDD VDD pmos_mod W=1u L=0.18u
M214 BUF_MID_98 BLOCK_OUT_97 GND GND nmos_mod W=1u L=0.18u
M215 C2 BUF_MID_98 VDD VDD pmos_mod W=1u L=0.18u
M216 C2 BUF_MID_98 GND GND nmos_mod W=1u L=0.18u
M217 BLOCK_OUT_99 P0 GND VDD pmos_mod W=1u L=0.18u
M218 P0_INV_100 P0 VDD VDD pmos_mod W=1u L=0.18u
M219 P0_INV_100 P0 GND GND nmos_mod W=1u L=0.18u
M220 P1 P0_INV_100 BLOCK_OUT_99 VDD pmos_mod W=1u L=0.18u
M221 BLOCK_OUT_101 BLOCK_OUT_99 GND VDD pmos_mod W=1u L=0.18u
M222 BLOCK_OUT_99_INV_102 BLOCK_OUT_99 VDD VDD pmos_mod W=1u L=0.18u
M223 BLOCK_OUT_99_INV_102 BLOCK_OUT_99 GND GND nmos_mod W=1u L=0.18u
M224 P2 BLOCK_OUT_99_INV_102 BLOCK_OUT_101 VDD pmos_mod W=1u L=0.18u
M225 BLOCK_OUT_103 BLOCK_OUT_101 GND VDD pmos_mod W=1u L=0.18u
M226 BLOCK_OUT_101_INV_104 BLOCK_OUT_101 VDD VDD pmos_mod W=1u L=0.18u
M227 BLOCK_OUT_101_INV_104 BLOCK_OUT_101 GND GND nmos_mod W=1u L=0.18u
M228 P3 BLOCK_OUT_101_INV_104 BLOCK_OUT_103 VDD pmos_mod W=1u L=0.18u
M229 BLOCK_OUT_105 BLOCK_OUT_103 VDD VDD pmos_mod W=1u L=0.18u
M230 BLOCK_OUT_105 BLOCK_OUT_103 GND GND nmos_mod W=1u L=0.18u
M231 BUF_MID_106 BLOCK_OUT_105 VDD VDD pmos_mod W=1u L=0.18u
M232 BUF_MID_106 BLOCK_OUT_105 GND GND nmos_mod W=1u L=0.18u
M233 X_OUT BUF_MID_106 VDD VDD pmos_mod W=1u L=0.18u
M234 X_OUT BUF_MID_106 GND GND nmos_mod W=1u L=0.18u
M235 C0 P0 BLOCK_OUT_107 VDD pmos_mod W=1u L=0.18u
M236 C0_INV_108 C0 VDD VDD pmos_mod W=1u L=0.18u
M237 C0_INV_108 C0 GND GND nmos_mod W=1u L=0.18u
M238 C0_INV_108 P0_INV_100 BLOCK_OUT_107 VDD pmos_mod W=1u L=0.18u
M239 BUF_MID_109 BLOCK_OUT_107 VDD VDD pmos_mod W=1u L=0.18u
M240 BUF_MID_109 BLOCK_OUT_107 GND GND nmos_mod W=1u L=0.18u
M241 F0 BUF_MID_109 VDD VDD pmos_mod W=1u L=0.18u
M242 F0 BUF_MID_109 GND GND nmos_mod W=1u L=0.18u
M243 BLOCK_OUT_110 G2 GND VDD pmos_mod W=1u L=0.18u
M244 G2_INV_111 G2 VDD VDD pmos_mod W=1u L=0.18u
M245 G2_INV_111 G2 GND GND nmos_mod W=1u L=0.18u
M246 P3 G2_INV_111 BLOCK_OUT_110 VDD pmos_mod W=1u L=0.18u
M247 BLOCK_OUT_112 G1 GND VDD pmos_mod W=1u L=0.18u
M248 G1_INV_113 G1 VDD VDD pmos_mod W=1u L=0.18u
M249 G1_INV_113 G1 GND GND nmos_mod W=1u L=0.18u
M250 P2 G1_INV_113 BLOCK_OUT_112 VDD pmos_mod W=1u L=0.18u
M251 BLOCK_OUT_114 BLOCK_OUT_112 GND VDD pmos_mod W=1u L=0.18u
M252 BLOCK_OUT_112_INV_115 BLOCK_OUT_112 VDD VDD pmos_mod W=1u L=0.18u
M253 BLOCK_OUT_112_INV_115 BLOCK_OUT_112 GND GND nmos_mod W=1u L=0.18u
M254 P3 BLOCK_OUT_112_INV_115 BLOCK_OUT_114 VDD pmos_mod W=1u L=0.18u
M255 BLOCK_OUT_116 BLOCK_OUT_86 GND VDD pmos_mod W=1u L=0.18u
M256 P2 BLOCK_OUT_86_INV_92 BLOCK_OUT_116 VDD pmos_mod W=1u L=0.18u
M257 BLOCK_OUT_117 BLOCK_OUT_116 GND VDD pmos_mod W=1u L=0.18u
M258 BLOCK_OUT_116_INV_118 BLOCK_OUT_116 VDD VDD pmos_mod W=1u L=0.18u
M259 BLOCK_OUT_116_INV_118 BLOCK_OUT_116 GND GND nmos_mod W=1u L=0.18u
M260 P3 BLOCK_OUT_116_INV_118 BLOCK_OUT_117 VDD pmos_mod W=1u L=0.18u
M261 BLOCK_OUT_119 BLOCK_OUT_89 GND VDD pmos_mod W=1u L=0.18u
M262 BLOCK_OUT_89_INV_120 BLOCK_OUT_89 VDD VDD pmos_mod W=1u L=0.18u
M263 BLOCK_OUT_89_INV_120 BLOCK_OUT_89 GND GND nmos_mod W=1u L=0.18u
M264 P2 BLOCK_OUT_89_INV_120 BLOCK_OUT_119 VDD pmos_mod W=1u L=0.18u
M265 BLOCK_OUT_121 BLOCK_OUT_119 GND VDD pmos_mod W=1u L=0.18u
M266 BLOCK_OUT_119_INV_122 BLOCK_OUT_119 VDD VDD pmos_mod W=1u L=0.18u
M267 BLOCK_OUT_119_INV_122 BLOCK_OUT_119 GND GND nmos_mod W=1u L=0.18u
M268 P3 BLOCK_OUT_119_INV_122 BLOCK_OUT_121 VDD pmos_mod W=1u L=0.18u
M269 BLOCK_OUT_114 BLOCK_OUT_110 BLOCK_OUT_123 VDD pmos_mod W=1u L=0.18u
M270 BLOCK_OUT_110_INV_124 BLOCK_OUT_110 VDD VDD pmos_mod W=1u L=0.18u
M271 BLOCK_OUT_110_INV_124 BLOCK_OUT_110 GND GND nmos_mod W=1u L=0.18u
M272 BLOCK_OUT_123 BLOCK_OUT_110_INV_124 VDD VDD pmos_mod W=1u L=0.18u
M273 BLOCK_OUT_117 BLOCK_OUT_123 BLOCK_OUT_125 VDD pmos_mod W=1u L=0.18u
M274 BLOCK_OUT_123_INV_126 BLOCK_OUT_123 VDD VDD pmos_mod W=1u L=0.18u
M275 BLOCK_OUT_123_INV_126 BLOCK_OUT_123 GND GND nmos_mod W=1u L=0.18u
M276 BLOCK_OUT_125 BLOCK_OUT_123_INV_126 VDD VDD pmos_mod W=1u L=0.18u
M277 BLOCK_OUT_121 BLOCK_OUT_125 BLOCK_OUT_127 VDD pmos_mod W=1u L=0.18u
M278 BLOCK_OUT_125_INV_128 BLOCK_OUT_125 VDD VDD pmos_mod W=1u L=0.18u
M279 BLOCK_OUT_125_INV_128 BLOCK_OUT_125 GND GND nmos_mod W=1u L=0.18u
M280 BLOCK_OUT_127 BLOCK_OUT_125_INV_128 VDD VDD pmos_mod W=1u L=0.18u
M281 G3 BLOCK_OUT_127 BLOCK_OUT_129 VDD pmos_mod W=1u L=0.18u
M282 BLOCK_OUT_127_INV_130 BLOCK_OUT_127 VDD VDD pmos_mod W=1u L=0.18u
M283 BLOCK_OUT_127_INV_130 BLOCK_OUT_127 GND GND nmos_mod W=1u L=0.18u
M284 BLOCK_OUT_129 BLOCK_OUT_127_INV_130 VDD VDD pmos_mod W=1u L=0.18u
M285 BLOCK_OUT_131 BLOCK_OUT_129 VDD VDD pmos_mod W=1u L=0.18u
M286 BLOCK_OUT_131 BLOCK_OUT_129 GND GND nmos_mod W=1u L=0.18u
M287 BUF_MID_132 BLOCK_OUT_131 VDD VDD pmos_mod W=1u L=0.18u
M288 BUF_MID_132 BLOCK_OUT_131 GND GND nmos_mod W=1u L=0.18u
M289 Cn4_OUT BUF_MID_132 VDD VDD pmos_mod W=1u L=0.18u
M290 Cn4_OUT BUF_MID_132 GND GND nmos_mod W=1u L=0.18u
M291 BLOCK_OUT_116 BLOCK_OUT_112 BLOCK_OUT_133 VDD pmos_mod W=1u L=0.18u
M292 BLOCK_OUT_133 BLOCK_OUT_112_INV_115 VDD VDD pmos_mod W=1u L=0.18u
M293 BLOCK_OUT_119 BLOCK_OUT_133 BLOCK_OUT_134 VDD pmos_mod W=1u L=0.18u
M294 BLOCK_OUT_133_INV_135 BLOCK_OUT_133 VDD VDD pmos_mod W=1u L=0.18u
M295 BLOCK_OUT_133_INV_135 BLOCK_OUT_133 GND GND nmos_mod W=1u L=0.18u
M296 BLOCK_OUT_134 BLOCK_OUT_133_INV_135 VDD VDD pmos_mod W=1u L=0.18u
M297 G2 BLOCK_OUT_134 BLOCK_OUT_136 VDD pmos_mod W=1u L=0.18u
M298 BLOCK_OUT_134_INV_137 BLOCK_OUT_134 VDD VDD pmos_mod W=1u L=0.18u
M299 BLOCK_OUT_134_INV_137 BLOCK_OUT_134 GND GND nmos_mod W=1u L=0.18u
M300 BLOCK_OUT_136 BLOCK_OUT_134_INV_137 VDD VDD pmos_mod W=1u L=0.18u
M301 M BLOCK_OUT_136 BLOCK_OUT_138 VDD pmos_mod W=1u L=0.18u
M302 BLOCK_OUT_136_INV_139 BLOCK_OUT_136 VDD VDD pmos_mod W=1u L=0.18u
M303 BLOCK_OUT_136_INV_139 BLOCK_OUT_136 GND GND nmos_mod W=1u L=0.18u
M304 BLOCK_OUT_138 BLOCK_OUT_136_INV_139 VDD VDD pmos_mod W=1u L=0.18u
M305 BLOCK_OUT_140 BLOCK_OUT_138 VDD VDD pmos_mod W=1u L=0.18u
M306 BLOCK_OUT_140 BLOCK_OUT_138 GND GND nmos_mod W=1u L=0.18u
M307 BUF_MID_141 BLOCK_OUT_140 VDD VDD pmos_mod W=1u L=0.18u
M308 BUF_MID_141 BLOCK_OUT_140 GND GND nmos_mod W=1u L=0.18u
M309 C3 BUF_MID_141 VDD VDD pmos_mod W=1u L=0.18u
M310 C3 BUF_MID_141 GND GND nmos_mod W=1u L=0.18u
M311 G3 BLOCK_OUT_125 BLOCK_OUT_142 VDD pmos_mod W=1u L=0.18u
M312 BLOCK_OUT_142 BLOCK_OUT_125_INV_128 VDD VDD pmos_mod W=1u L=0.18u
M313 BLOCK_OUT_143 BLOCK_OUT_142 VDD VDD pmos_mod W=1u L=0.18u
M314 BLOCK_OUT_143 BLOCK_OUT_142 GND GND nmos_mod W=1u L=0.18u
M315 BUF_MID_144 BLOCK_OUT_143 VDD VDD pmos_mod W=1u L=0.18u
M316 BUF_MID_144 BLOCK_OUT_143 GND GND nmos_mod W=1u L=0.18u
M317 Y_OUT BUF_MID_144 VDD VDD pmos_mod W=1u L=0.18u
M318 Y_OUT BUF_MID_144 GND GND nmos_mod W=1u L=0.18u
M319 G0 BLOCK_OUT_88 BLOCK_OUT_145 VDD pmos_mod W=1u L=0.18u
M320 BLOCK_OUT_145 BLOCK_OUT_88_INV_90 VDD VDD pmos_mod W=1u L=0.18u
M321 M BLOCK_OUT_145 BLOCK_OUT_146 VDD pmos_mod W=1u L=0.18u
M322 BLOCK_OUT_145_INV_147 BLOCK_OUT_145 VDD VDD pmos_mod W=1u L=0.18u
M323 BLOCK_OUT_145_INV_147 BLOCK_OUT_145 GND GND nmos_mod W=1u L=0.18u
M324 BLOCK_OUT_146 BLOCK_OUT_145_INV_147 VDD VDD pmos_mod W=1u L=0.18u
M325 BLOCK_OUT_148 BLOCK_OUT_146 VDD VDD pmos_mod W=1u L=0.18u
M326 BLOCK_OUT_148 BLOCK_OUT_146 GND GND nmos_mod W=1u L=0.18u
M327 BUF_MID_149 BLOCK_OUT_148 VDD VDD pmos_mod W=1u L=0.18u
M328 BUF_MID_149 BLOCK_OUT_148 GND GND nmos_mod W=1u L=0.18u
M329 C1 BUF_MID_149 VDD VDD pmos_mod W=1u L=0.18u
M330 C1 BUF_MID_149 GND GND nmos_mod W=1u L=0.18u
M331 C3 P3 BLOCK_OUT_150 VDD pmos_mod W=1u L=0.18u
M332 P3_INV_151 P3 VDD VDD pmos_mod W=1u L=0.18u
M333 P3_INV_151 P3 GND GND nmos_mod W=1u L=0.18u
M334 C3_INV_152 C3 VDD VDD pmos_mod W=1u L=0.18u
M335 C3_INV_152 C3 GND GND nmos_mod W=1u L=0.18u
M336 C3_INV_152 P3_INV_151 BLOCK_OUT_150 VDD pmos_mod W=1u L=0.18u
M337 BUF_MID_153 BLOCK_OUT_150 VDD VDD pmos_mod W=1u L=0.18u
M338 BUF_MID_153 BLOCK_OUT_150 GND GND nmos_mod W=1u L=0.18u
M339 F3 BUF_MID_153 VDD VDD pmos_mod W=1u L=0.18u
M340 F3 BUF_MID_153 GND GND nmos_mod W=1u L=0.18u
M341 C1 P1 BLOCK_OUT_154 VDD pmos_mod W=1u L=0.18u
M342 P1_INV_155 P1 VDD VDD pmos_mod W=1u L=0.18u
M343 P1_INV_155 P1 GND GND nmos_mod W=1u L=0.18u
M344 C1_INV_156 C1 VDD VDD pmos_mod W=1u L=0.18u
M345 C1_INV_156 C1 GND GND nmos_mod W=1u L=0.18u
M346 C1_INV_156 P1_INV_155 BLOCK_OUT_154 VDD pmos_mod W=1u L=0.18u
M347 BUF_MID_157 BLOCK_OUT_154 VDD VDD pmos_mod W=1u L=0.18u
M348 BUF_MID_157 BLOCK_OUT_154 GND GND nmos_mod W=1u L=0.18u
M349 F1 BUF_MID_157 VDD VDD pmos_mod W=1u L=0.18u
M350 F1 BUF_MID_157 GND GND nmos_mod W=1u L=0.18u
M351 C2 P2 BLOCK_OUT_158 VDD pmos_mod W=1u L=0.18u
M352 P2_INV_159 P2 VDD VDD pmos_mod W=1u L=0.18u
M353 P2_INV_159 P2 GND GND nmos_mod W=1u L=0.18u
M354 C2_INV_160 C2 VDD VDD pmos_mod W=1u L=0.18u
M355 C2_INV_160 C2 GND GND nmos_mod W=1u L=0.18u
M356 C2_INV_160 P2_INV_159 BLOCK_OUT_158 VDD pmos_mod W=1u L=0.18u
M357 BUF_MID_161 BLOCK_OUT_158 VDD VDD pmos_mod W=1u L=0.18u
M358 BUF_MID_161 BLOCK_OUT_158 GND GND nmos_mod W=1u L=0.18u
M359 F2 BUF_MID_161 VDD VDD pmos_mod W=1u L=0.18u
M360 F2 BUF_MID_161 GND GND nmos_mod W=1u L=0.18u
M361 BLOCK_OUT_162 F0 GND VDD pmos_mod W=1u L=0.18u
M362 F0_INV_163 F0 VDD VDD pmos_mod W=1u L=0.18u
M363 F0_INV_163 F0 GND GND nmos_mod W=1u L=0.18u
M364 F1 F0_INV_163 BLOCK_OUT_162 VDD pmos_mod W=1u L=0.18u
M365 BLOCK_OUT_164 BLOCK_OUT_162 GND VDD pmos_mod W=1u L=0.18u
M366 BLOCK_OUT_162_INV_165 BLOCK_OUT_162 VDD VDD pmos_mod W=1u L=0.18u
M367 BLOCK_OUT_162_INV_165 BLOCK_OUT_162 GND GND nmos_mod W=1u L=0.18u
M368 F2 BLOCK_OUT_162_INV_165 BLOCK_OUT_164 VDD pmos_mod W=1u L=0.18u
M369 BLOCK_OUT_166 BLOCK_OUT_164 GND VDD pmos_mod W=1u L=0.18u
M370 BLOCK_OUT_164_INV_167 BLOCK_OUT_164 VDD VDD pmos_mod W=1u L=0.18u
M371 BLOCK_OUT_164_INV_167 BLOCK_OUT_164 GND GND nmos_mod W=1u L=0.18u
M372 F3 BLOCK_OUT_164_INV_167 BLOCK_OUT_166 VDD pmos_mod W=1u L=0.18u
M373 BUF_MID_168 BLOCK_OUT_166 VDD VDD pmos_mod W=1u L=0.18u
M374 BUF_MID_168 BLOCK_OUT_166 GND GND nmos_mod W=1u L=0.18u
M375 A_EQ_B BUF_MID_168 VDD VDD pmos_mod W=1u L=0.18u
M376 A_EQ_B BUF_MID_168 GND GND nmos_mod W=1u L=0.18u

* --- DEVICE MODELS ---
.model pmos_mod PMOS (VTO=-0.7 KP=20u GAMMA=0.4)
.model nmos_mod NMOS (VTO=0.7 KP=50u GAMMA=0.4)

.end
